# Ansys Electronics Desktop project, version 2023.2
materials:
  vacuum: permittivity=1

design HFSSDesign1 (HFSS, HFSS Modal Network, model units mm)
geometry:
  mybox [vacuum] = box(corner=(0mm, 0mm, 0mm), size=(22mm, 10mm, 60mm))
boundaries and excitations:
  1: Wave Port Faces=mybox.face(+z) WavePortType=Modal NumModes=5 Modes{Mode1{CharImp=Zpi} Mode2{CharImp=Zpi} Mode3{CharImp=Zpi} Mode4{CharImp=Zpi} Mode5{CharImp=Zpi}}
  2: Wave Port Faces=mybox.face(-z) WavePortType=Modal NumModes=5 Modes{Mode1{CharImp=Zpi} Mode2{CharImp=Zpi} Mode3{CharImp=Zpi} Mode4{CharImp=Zpi} Mode5{CharImp=Zpi}}
setups:
  Setup1: HfssDriven Frequency=10GHz MaxDeltaS=0.02 MaximumPasses=6 MinimumPasses=1 MinimumConvergedPasses=1 PercentRefinement=30 BasisOrder=1 PortAccuracy=2 DrivenSolverType="Direct Solver"
    sweep Sweep: 8GHz to 12GHz, 401 points; Type=Interpolating SaveFields InterpTolerance=0.5 InterpMaxSolns=250 InterpUsePortImped=false PassivityErrorTolerance=0.0001
  Setup2: HfssDriven Frequency=16GHz MaxDeltaS=0.02 MaximumPasses=6 MinimumPasses=1 MinimumConvergedPasses=1 PercentRefinement=30 BasisOrder=1 PortAccuracy=2 DrivenSolverType="Direct Solver"
    sweep Sweep: 8GHz to 24GHz, 401 points; Type=Interpolating InterpTolerance=0.5 InterpMaxSolns=250 InterpUsePortImped=false PassivityErrorTolerance=0.0001
source amplitudes:
  1:1: 1W 0deg
  1:2..1:5, 2:1..2:5: 0W 0deg
field plots:
  Vector_H1: H Field over mybox.face(+z) on Setup1 : Sweep at Freq=8GHz Phase=0deg
  Vector_E1: E Field over mybox.face(+z) on Setup1 : LastAdaptive at Freq=10GHz Phase=0deg
